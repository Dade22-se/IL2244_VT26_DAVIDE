ADE simulation setup
Run mode: Single Run, Sweeps and Corners
Tests:
  VGA:VGA_1_tb:1 (off): VGA/VGA_1_tb/schematic, simulator spectre
    Outputs: OUT NOISE
  Linerity (off): VGA/VGA_1_tb/schematic, simulator spectre
    Outputs: OUT NOISE
  MC (off): VGA/VGA_1_tb/schematic, simulator spectre
    Outputs: OUT NOISE
  wakeup: VGA/VGA_1_wakeup_tb/schematic, simulator spectre
    Outputs: OUT NOISE
  VGA:VGA_1_tb:1:1 (off): VGA/VGA_1_tb/schematic, simulator spectre
    Outputs: OUT NOISE
  xf (off): VGA/VGA_1_tb/schematic, simulator spectre
    Outputs: OUT NOISE
  wakeup_MC (off): VGA/VGA_1_wakeup_tb/schematic, simulator spectre
    Outputs: OUT NOISE
Global variables:
  S0 = 3.3
  S1 = 3.3
  S2 = 3.3
  S3 = 3.3
  V_AMP = 80m (off)
  VDD = 3.3 (off)
  VIN_PULSE = 0
  V_FREQ = 1k (off)
  tf = 0 (off)
  tr = 0 (off)
  TF = 1u
  TR = 1u
Corners (all switched off):
  model folders: /opt/pdk/ams/410/spectre/c35/soac
  every corner: /opt/pdk/ams/410/spectre/c35/soac/processOption.scs, /opt/pdk/ams/410/spectre/c35/soac/cmos53.scs[cmoswo cmoswp cmosws cmoswz], /opt/pdk/ams/410/spectre/c35/soac/res.scs[restm], /opt/pdk/ams/410/spectre/c35/soac/bip.scs[biptm], /opt/pdk/ams/410/spectre/c35/soac/ind.scs[indtm], /opt/pdk/ams/410/spectre/c35/soac/esddiode.scs[esddiodetm]
  CMOS (off): cap.scs[captm]
  VDD (off): VDD=2.97 3.63; cap.scs[captm]
  CMOS_CAP_VDD (off): VDD=2.97 3.63; cap.scs[capwp capws]
  CMOS_CAP_VDD_TEMP (off): temperature=-40 85; VDD=2.97 3.63; cap.scs[capwp capws]
  CMOS_CAP_VDD_TEMP_RAMP: temperature=-40 85; cap.scs[capwp capws]
