ADE simulation setup
Run mode: Single Run, Sweeps and Corners
Tests:
  VGA_VGA_1_pss_tb_1: VGA/VGA_1_pss_tb/schematic, simulator spectre
    Variables: S0 = 3.3; S1 = 3.3; S2 = 3.3; S3 = 3.3; V_AMP = 20m; V_FREQ = 50; VDD = 3.3
    Outputs: VOUT_filt; VOUT; d2_db
  MC (off): VGA/VGA_1_pss_tb/schematic, simulator spectre
    Variables: S0 = 3.3; S1 = 3.3; S2 = 3.3; S3 = 3.3; V_AMP = 20m; V_FREQ = 50; VDD = 3.3
    Outputs: VOUT_filt; VOUT; d2_db
Corners:
  model folders: /opt/pdk/ams/410/spectre/c35
  every corner: /opt/pdk/ams/410/spectre/c35/processOption.scs, /opt/pdk/ams/410/spectre/c35/cmos53.scs[cmoswo cmoswp cmosws cmoswz], /opt/pdk/ams/410/spectre/c35/res.scs[restm], /opt/pdk/ams/410/spectre/c35/bip.scs[biptm], /opt/pdk/ams/410/spectre/c35/ind.scs[indtm], /opt/pdk/ams/410/spectre/c35/esddiode.scs[esddiodetm]
  CMOS (off): cap.scs[captm]
  VDD (off): VDD=2.97 3.63; cap.scs[captm]
  CMOS_CAP_VDD (off): VDD=2.97 3.63; cap.scs[capwp capws]
  CMOS_CAP_VDD_TEMP: temperature=-40 85; VDD=2.97 3.63; cap.scs[capwp capws]
  CMOS_CAP_VDD_TEMP_RAMP (off): temperature=-40 85; cap.scs[capwp capws]
