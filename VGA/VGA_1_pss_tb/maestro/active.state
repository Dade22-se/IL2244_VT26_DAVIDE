ADE simulation setup
Test VGA_VGA_1_pss_tb_1: VGA/VGA_1_pss_tb/schematic, simulator spectre
  Models: /opt/pdk/ams/410/spectre/c35/processOption.scs, /opt/pdk/ams/410/spectre/c35/cmos53.scs[cmostm], /opt/pdk/ams/410/spectre/c35/res.scs[restm], /opt/pdk/ams/410/spectre/c35/cap.scs[captm], /opt/pdk/ams/410/spectre/c35/bip.scs[biptm], /opt/pdk/ams/410/spectre/c35/ind.scs[indtm], /opt/pdk/ams/410/spectre/c35/esddiode.scs[esddiodetm]
  Variables: S0 = 3.3; S1 = 3.3; S2 = 3.3; S3 = 3.3; V_AMP = 20m; V_FREQ = 50; VDD = 3.3
  Temperature: 27
  Simulator options: reltol=100e-6 homotopy=all limit=delta additionalArgs=enable_pre_ver=yes ignorezerovar=yes
  Files: definitions /opt/pdk/ams/410/spectre/c35/soac/soac.scs
  Analysis pss: engine=Shooting fund=50 harms=80 errpreset=conservative
  Analysis tran: stop=100m errpreset=conservative
  Output v /vout; pss (V) = vtime('pss "/vout")
  Output v /vout_filt; pss (V) = vtime('pss "/vout_filt")
  Output v /vout_filt; pss dB20(V) = db(vh('pss "/vout_filt"))
  Output v /vout; pss dB20(V) = db(vh('pss "/vout"))
  Output d2_db = (harmonic(db(vh('pss "/vout")) 1) - harmonic(db(vh('pss "/vout")) 2))
  Signals: /vout_filt as VOUT_filt, /vout as VOUT
Test MC: VGA/VGA_1_pss_tb/schematic, simulator spectre
  Models: /opt/pdk/ams/410/spectre/c35/processOption.scs, /opt/pdk/ams/410/spectre/c35/cmos53.scs[cmosmc], /opt/pdk/ams/410/spectre/c35/res.scs[resmc], /opt/pdk/ams/410/spectre/c35/cap.scs[capmc], /opt/pdk/ams/410/spectre/c35/bip.scs[bipmc], /opt/pdk/ams/410/spectre/c35/ind.scs[indmc], /opt/pdk/ams/410/spectre/c35/esddiode.scs[esddiodemc]
  Variables: S0 = 3.3; S1 = 3.3; S2 = 3.3; S3 = 3.3; V_AMP = 20m; V_FREQ = 50; VDD = 3.3
  Temperature: 27
  Simulator options: reltol=100e-6 homotopy=all limit=delta additionalArgs=enable_pre_ver=yes ignorezerovar=yes
  Files: definitions /opt/pdk/ams/410/spectre/c35/soac/soac.scs
  Analysis pss: engine=Shooting fund=50 harms=80 errpreset=conservative
  Analysis tran: stop=100m errpreset=conservative
  Output v /vout; pss (V) = vtime('pss "/vout")
  Output v /vout_filt; pss (V) = vtime('pss "/vout_filt")
  Output v /vout_filt; pss dB20(V) = db(vh('pss "/vout_filt"))
  Output v /vout; pss dB20(V) = db(vh('pss "/vout"))
  Output d2_db = (harmonic(db(vh('pss "/vout")) 1) - harmonic(db(vh('pss "/vout")) 2))
  Signals: /vout_filt as VOUT_filt, /vout as VOUT
Run mode: Single Run, Sweeps and Corners
Corners:
  model folders: /opt/pdk/ams/410/spectre/c35
  every corner: /opt/pdk/ams/410/spectre/c35/processOption.scs, /opt/pdk/ams/410/spectre/c35/cmos53.scs[cmoswo cmoswp cmosws cmoswz], /opt/pdk/ams/410/spectre/c35/res.scs[restm], /opt/pdk/ams/410/spectre/c35/bip.scs[biptm], /opt/pdk/ams/410/spectre/c35/ind.scs[indtm], /opt/pdk/ams/410/spectre/c35/esddiode.scs[esddiodetm]
  CMOS (off): cap.scs[captm]
  VDD (off): VDD=2.97 3.63; cap.scs[captm]
  CMOS_CAP_VDD (off): VDD=2.97 3.63; cap.scs[capwp capws]
  CMOS_CAP_VDD_TEMP: temperature=-40 85; VDD=2.97 3.63; cap.scs[capwp capws]
  CMOS_CAP_VDD_TEMP_RAMP (off): temperature=-40 85; cap.scs[capwp capws]
Disabled tests: MC
