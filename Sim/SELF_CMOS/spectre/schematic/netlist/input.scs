// Design: CHARACTERIZATION/SELF_CMOS
simulator lang=spectre
global 0
include "/opt/pdk/ams/410/spectre/c35/soac/soac.scs"
parameters W1=1e-05 L1=4e-06 NF1=10 VDS2=1.5 VDS1=1.5 IDS2=5e-07 IDS1=1e-06 W2=1e-05 L2=4e-06 NF2=10
include "/opt/pdk/ams/410/spectre/c35/soac/processOption.scs"
include "/opt/pdk/ams/410/spectre/c35/soac/cmos53.scs" section=cmostm
include "/opt/pdk/ams/410/spectre/c35/soac/res.scs" section=restm
include "/opt/pdk/ams/410/spectre/c35/soac/cap.scs" section=captm
include "/opt/pdk/ams/410/spectre/c35/soac/bip.scs" section=biptm
include "/opt/pdk/ams/410/spectre/c35/soac/ind.scs" section=indtm
include "/opt/pdk/ams/410/spectre/c35/soac/esddiode.scs" section=esddiodetm

// CHARACTERIZATION/SELF_CMOS/schematic
MN0 (net2 net3 0 0) modn w=W1 l=L1 ng=NF1
V2 (net4 0) vsource dc=3.3 type=dc
V1 (net4 net7) vsource dc=VDS2 type=dc
V0 (net1 0) vsource dc=VDS1 type=dc
E1 (net4 net6 net7 net5) vcvs gain=1000 min=0 max=3.3
E0 (net3 0 net2 net1) vcvs gain=1000 min=0 max=3.3
I2 (net5 net4) isource dc=IDS2 type=dc
I1 (0 net2) isource dc=IDS1 type=dc
MP0 (net5 net6 net4 net4) modp w=W2 l=L2 ng=NF2
simulatorOptions options reltol=100e-6 temp=27 homotopy=all limit=delta compatible=spice2 enable_pre_ver=yes ignorezerovar=yes
dcOp dc
