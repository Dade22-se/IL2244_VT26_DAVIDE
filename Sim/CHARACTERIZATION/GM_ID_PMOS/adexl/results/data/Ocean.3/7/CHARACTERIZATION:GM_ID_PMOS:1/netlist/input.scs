// Design: CHARACTERIZATION/GM_ID_PMOS
simulator lang=spectre
global 0
include "/opt/pdk/ams/410/spectre/c35/soac/soac.scs"
parameters temperature=27 W=10e-6 NF=10 L=4e-6 VDS=1.5 IDS=2.511886432n
include "/opt/pdk/ams/410/spectre/c35/soac/processOption.scs"
include "/opt/pdk/ams/410/spectre/c35/soac/cmos53.scs" section=cmostm
include "/opt/pdk/ams/410/spectre/c35/soac/res.scs" section=restm
include "/opt/pdk/ams/410/spectre/c35/soac/cap.scs" section=captm
include "/opt/pdk/ams/410/spectre/c35/soac/bip.scs" section=biptm
include "/opt/pdk/ams/410/spectre/c35/soac/ind.scs" section=indtm
include "/opt/pdk/ams/410/spectre/c35/soac/esddiode.scs" section=esddiodetm

// CHARACTERIZATION/GM_ID_PMOS/schematic
E1 (net3 net1 net4 net2) vcvs gain=1000 min=0 max=3.3
I2 (net2 net3) isource dc=IDS type=dc
V2 (net3 0) vsource dc=3.3 type=dc
V1 (net3 net4) vsource dc=VDS type=dc
MP0 (net2 net1 net3 net3) modp w=W l=L ng=NF
simulatorOptions options reltol=100e-6 temp=27 homotopy=all limit=delta compatible=spice2 enable_pre_ver=yes ignorezerovar=yes
dcOp dc
