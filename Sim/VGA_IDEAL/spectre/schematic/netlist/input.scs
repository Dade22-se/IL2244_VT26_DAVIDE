// Design: VGA/VGA_IDEAL
simulator lang=spectre
global 0
include "/opt/pdk/ams/410/spectre/c35/soac/soac.scs"
include "/opt/pdk/ams/410/spectre/c35/soac/processOption.scs"
include "/opt/pdk/ams/410/spectre/c35/soac/cmos53.scs" section=cmostm
include "/opt/pdk/ams/410/spectre/c35/soac/res.scs" section=restm
include "/opt/pdk/ams/410/spectre/c35/soac/cap.scs" section=captm
include "/opt/pdk/ams/410/spectre/c35/soac/bip.scs" section=biptm
include "/opt/pdk/ams/410/spectre/c35/soac/ind.scs" section=indtm
include "/opt/pdk/ams/410/spectre/c35/soac/esddiode.scs" section=esddiodetm

// VGA/VGA_IDEAL/schematic
I7 (net4 net1) isource dc=1 type=sine
MP2 (net4 0 net3 VDD) modp w=10u l=4u ng=10
MP1 (net1 vin net3 VDD) modp w=10u l=4u ng=10
C2 (vin out) capacitor c=500f
C1 (vin 0) capacitor c=39.5p
C0 (out 0) capacitor c=150f
V1 (vin 0) vsource dc=0 mag=1 type=pulse val0=0 val1=3.3 period=1u delay=0 rise=1n fall=1n width=500.0n
MN3 (out net3 0 0) modn w=5u l=1u ng=2
V0 (VDD 0) vsource dc=3.3 type=dc
simulatorOptions options reltol=100e-6 temp=27 homotopy=all limit=delta compatible=spice2 enable_pre_ver=yes ignorezerovar=yes
dcOp dc
tran tran stop=500u errpreset=conservative
ac ac start=0.01 stop=10G
