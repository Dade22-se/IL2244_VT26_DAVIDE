// Design: ECG_IA/ecg_tb
simulator lang=spectre
global 0
include "/opt/pdk/ams/410/spectre/c35/soac/soac.scs"
parameters temperature=27 VIN_STEP=0 VDD_STEP=0 S0=3.3 S1=3.3 S2=3.3 T0=0 T1=0 T2=0 VIN_FREQ=50 VIN_AMP=1m FC=2K VCM_AC=1 VCM_DC=1.6 VDD=3.3 VIN_AC=1 VIN_DC=0
include "/opt/pdk/ams/410/spectre/c35/processOption.scs"
include "/opt/pdk/ams/410/spectre/c35/cmos53.scs" section=cmostm
include "/opt/pdk/ams/410/spectre/c35/res.scs" section=restm
include "/opt/pdk/ams/410/spectre/c35/cap.scs" section=captm
include "/opt/pdk/ams/410/spectre/c35/bip.scs" section=biptm
include "/opt/pdk/ams/410/spectre/c35/ind.scs" section=indtm
include "/opt/pdk/ams/410/spectre/c35/esddiode.scs" section=esddiodetm

// PRIMLIB/rpolyhc/schematic
subckt rpolyhc PLUS MINUS REF
parameters w=10u l=10u mult=1 mmw=0 cap=14.34f
    R1 (PLUS net9) rpolyh w=w l=(0.5 * l) m=mult mmw=mmw
    R2 (net9 MINUS) rpolyh w=w l=(0.5*l) m=mult mmw=mmw
    CS0 (PLUS REF) capacitor c=(1-0.5*(1+tanh(l/200/w)))*cap/2 m=mult
    CS1 (MINUS REF) capacitor c=(1-0.5*(1+tanh(l/200/w)))*cap/2 m=mult
    CM (net9 REF) capacitor c=(0.5*(1+tanh(l/200/w))*cap) m=mult
ends rpolyhc

// PRIMLIB/cpolyc/schematic
subckt cpolyc MINUS PLUS SUB
parameters pcap=15.5f area=100p perimeter=40u mmw=0
    C1 (MINUS SUB) capacitor c=pcap m=1
    C0 (PLUS MINUS) cpoly area=area perimeter=perimeter m=1 mmw=mmw
ends cpolyc

// ECG_IA/mux21/schematic
subckt mux21 A0 A1 C GNDA S VDDA
    MN2 (SN S GNDA GNDA) modn w=0.8u l=0.35u ng=1
    MN1 (A1 S C GNDA) modn w=4u l=0.35u ng=1
    MN0 (A0 SN C GNDA) modn w=4u l=0.35u ng=1
    MP0 (SN S VDDA VDDA) modp w=1.4u l=0.35u ng=1
ends mux21

// ECG_IA/ecg_vga4/schematic
subckt ecg_vga4 BIAS GNDA S\<2\> S\<1\> S\<0\> VDDA VIN VOUT
    MN9 (net15 BIAS net43 GNDA) modn w=10u l=8u ng=2
    MN7 (net43 net14 GNDA GNDA) modn w=10u l=12u ng=2
    MN17 (VOUT net41 GNDA GNDA) modn w=10u l=1u ng=2
    MN16 (net39 net39 GNDA GNDA) modn w=15u l=15u ng=2
    MN15 (net41 net39 GNDA GNDA) modn w=15u l=15u ng=2
    MN8 (BIAS BIAS net14 GNDA) modn w=10u l=8u ng=2
    MN4 (net14 net14 GNDA GNDA) modn w=10u l=12u ng=2
    R1 (net41 net1 GNDA) rpolyhc w=2u l=150u mult=1 mmw=0 cap=50.7f
    C8\<0\> (net7 B GNDA) cpolyc m=1 pcap=170.625f area=1.23n perimeter=140u mmw=0
    C8\<1\> (net7 B GNDA) cpolyc m=1 pcap=170.625f area=1.23n perimeter=140u mmw=0
    C8\<2\> (net7 B GNDA) cpolyc m=1 pcap=170.625f area=1.23n perimeter=140u mmw=0
    C8\<3\> (net7 B GNDA) cpolyc m=1 pcap=170.625f area=1.23n perimeter=140u mmw=0
    C8\<4\> (net7 B GNDA) cpolyc m=1 pcap=170.625f area=1.23n perimeter=140u mmw=0
    C8\<5\> (net7 B GNDA) cpolyc m=1 pcap=170.625f area=1.23n perimeter=140u mmw=0
    C8\<6\> (net7 B GNDA) cpolyc m=1 pcap=170.625f area=1.23n perimeter=140u mmw=0
    C8\<7\> (net7 B GNDA) cpolyc m=1 pcap=170.625f area=1.23n perimeter=140u mmw=0
    C6\<0\> (net9 B GNDA) cpolyc m=1 pcap=170.625f area=1.23n perimeter=140u mmw=0
    C6\<1\> (net9 B GNDA) cpolyc m=1 pcap=170.625f area=1.23n perimeter=140u mmw=0
    C7\<0\> (net8 B GNDA) cpolyc m=1 pcap=170.625f area=1.23n perimeter=140u mmw=0
    C7\<1\> (net8 B GNDA) cpolyc m=1 pcap=170.625f area=1.23n perimeter=140u mmw=0
    C7\<2\> (net8 B GNDA) cpolyc m=1 pcap=170.625f area=1.23n perimeter=140u mmw=0
    C7\<3\> (net8 B GNDA) cpolyc m=1 pcap=170.625f area=1.23n perimeter=140u mmw=0
    C4 (VOUT B GNDA) cpolyc m=1 pcap=170.625f area=1.23n perimeter=140u mmw=0
    C5 (GNDA B GNDA) cpolyc m=1 pcap=170.625f area=1.23n perimeter=140u mmw=0
    C9\<0\> (VOUT net1 GNDA) cpolyc m=1 pcap=170.625f area=1.23n perimeter=140u mmw=0
    C9\<1\> (VOUT net1 GNDA) cpolyc m=1 pcap=170.625f area=1.23n perimeter=140u mmw=0
    C9\<2\> (VOUT net1 GNDA) cpolyc m=1 pcap=170.625f area=1.23n perimeter=140u mmw=0
    MP7 (net2 net2 VOUT VOUT) modp w=1u l=0.35u ng=1
    MP5 (GNDA B net3 net3) modp w=6.25u l=0.35u ng=8
    MP3 (net3 net15 VDDA VDDA) modp w=10u l=15u ng=1
    MP8 (VOUT VOUT VOUT VOUT) modp w=1u l=0.35u ng=1
    MP1 (B B net44 net44) modp w=1u l=0.35u ng=1
    MP0 (net44 net44 net5 net5) modp w=1u l=0.35u ng=1
    MP2 (net5 net5 net2 net2) modp w=1u l=0.35u ng=1
    MP4 (net15 net15 VDDA VDDA) modp w=10u l=15u ng=2
    MP13 (net33 net15 VDDA VDDA) modp w=10u l=15u ng=10
    MP12 (VOUT net15 VDDA VDDA) modp w=10u l=15u ng=50
    MP10 (net41 VIN net33 net33) modp w=10u l=4u ng=10
    MP9 (net39 B net33 net33) modp w=10u l=4u ng=10
    I0 (net3 GNDA net9 GNDA S\<0\> VDDA) mux21
    I1 (net3 GNDA net8 GNDA S\<1\> VDDA) mux21
    I2 (net3 GNDA net7 GNDA S\<2\> VDDA) mux21
ends ecg_vga4

// ECG_IA/chopper/schematic
subckt chopper GNDA VDDA clk inn inp outn outp
    MP4 (clkn clk VDDA VDDA) modp w=1.4u l=0.35u ng=1
    MN0 (clkn clk GNDA GNDA) modn w=0.8u l=0.35u ng=1
    MP3 (outn clk inn GNDA) modn w=10u l=0.35u ng=2
    MP2 (outp clkn inn GNDA) modn w=10u l=0.35u ng=2
    MP1 (outn clkn inp GNDA) modn w=10u l=0.35u ng=2
    MP0 (outp clk inp GNDA) modn w=10u l=0.35u ng=2
ends chopper

// ECG_IA/ecg_ia8/schematic
subckt ecg_ia8 BIAS GNDA VDDA VINN VINP VOUT CLK
    MP24 (A net26 VDDA VDDA) modp w=2u l=30u ng=20
    MP23 (net26 net26 VDDA VDDA) modp w=2u l=30u ng=5
    MP21 (net11 net14 VDDA VDDA) modp w=10u l=12u ng=10
    MP22 (net24 INT net11 net11) modp w=1u l=40u ng=10
    MP20 (net21 VREF net11 net11) modp w=1u l=40u ng=10
    MP19 (INT net22 net3 VDDA) modp w=4u l=15u ng=5
    MP18 (net3 net22 VDDA VDDA) modp w=4u l=15u ng=5
    MP17 (net22 net22 VDDA VDDA) modp w=4u l=15u ng=5
    MP13 (net19 net14 VDDA VDDA) modp w=10u l=12u ng=5
    MP14 (net20 VOUT net9 net9) modp w=10u l=4u ng=10
    MP12 (VOUT net14 VDDA VDDA) modp w=10u l=12u ng=10
    MP10 (net18 VREF net19 net19) modp w=10u l=4u ng=10
    MP16 (net9 net14 VDDA VDDA) modp w=10u l=12u ng=1
    MP15 (net10 VREF net9 net9) modp w=10u l=4u ng=10
    MP9 (net5 A net19 net19) modp w=10u l=4u ng=10
    MP3 (net8 net6 VDDA VDDA) modp w=10u l=12u ng=4
    MP2 (net6 net6 VDDA VDDA) modp w=10u l=12u ng=4
    MP4 (net14 net14 VDDA VDDA) modp w=10u l=12u ng=2
    MP5 (net15 net14 VDDA VDDA) modp w=10u l=12u ng=30
    MP6 (net16 net14 VDDA VDDA) modp w=10u l=12u ng=30
    MP7 (A net7 net8 VDDA) modp w=10u l=4u ng=10
    MP8 (net7 net7 net6 VDDA) modp w=10u l=4u ng=10
    MP1 (net17 vinnc net16 net16) modp w=10u l=4u ng=20
    MP0 (net4 vinpc net15 net15) modp w=10u l=4u ng=20
    MN23 (net21 net21 GNDA GNDA) modn w=2u l=60u ng=4
    MN24 (net26 net24 GNDA GNDA) modn w=2u l=60u ng=4
    MN25 (net24 net24 GNDA GNDA) modn w=2u l=60u ng=4
    MN26 (A net21 GNDA GNDA) modn w=2u l=60u ng=16
    MN22 (INT net10 net23 GNDA) modn w=4u l=15u ng=4
    MN21 (net23 net10 GNDA GNDA) modn w=4u l=15u ng=4
    MN17 (VOUT net18 GNDA GNDA) modn w=1u l=2u ng=10
    MN16 (net5 net5 GNDA GNDA) modn w=10u l=8u ng=4
    MN15 (net18 net5 GNDA GNDA) modn w=10u l=8u ng=4
    MN14 (net16 BIAS net2 GNDA) modn w=1u l=4u ng=10
    MN13 (A BIAS D GNDA) modn w=1u l=4u ng=10
    MN11 (net15 BIAS net1 GNDA) modn w=1u l=4u ng=10
    MN10 (net7 BIAS B GNDA) modn w=1u l=4u ng=10
    MN9 (net14 BIAS net12 GNDA) modn w=10u l=8u ng=4
    MN18 (net20 net20 GNDA GNDA) modn w=4u l=15u ng=4
    MN20 (net22 net20 GNDA GNDA) modn w=4u l=15u ng=4
    MN19 (net10 net10 GNDA GNDA) modn w=4u l=15u ng=4
    MN7 (net12 net13 GNDA GNDA) modn w=2u l=80u ng=2
    MN6 (net17 net13 GNDA GNDA) modn w=2u l=80u ng=10
    MN3 (BC net4 GNDA GNDA) modn w=4u l=12u ng=4
    MN8 (BIAS BIAS net13 GNDA) modn w=10u l=8u ng=2
    MN2 (DC net17 GNDA GNDA) modn w=4u l=12u ng=4
    MN4 (net13 net13 GNDA GNDA) modn w=2u l=80u ng=1
    MN5 (net4 net13 GNDA GNDA) modn w=2u l=80u ng=10
    MN1 (net2 net17 GNDA GNDA) modn w=4u l=12u ng=4
    MN0 (net1 net4 GNDA GNDA) modn w=4u l=12u ng=4
    R1 (A VOUT) resistor r=1M
    R0 (net15 net16) resistor r=25k
    V3 (VREF GNDA) vsource dc=1.6 type=dc
    I9 (GNDA VDDA CLK D B DC BC) chopper
    I8 (GNDA VDDA CLK VINN VINP vinnc vinpc) chopper
    C2 (INT GNDA) capacitor c=4u
    C1 (net18 VOUT) capacitor c=3p
    C0 (A VOUT) capacitor c=5p
ends ecg_ia8

// ECG_IA/ecg_tb/schematic
V5 (S\<1\> 0) vsource dc=S1 type=dc
V6 (S\<2\> 0) vsource dc=S2 type=dc
V4 (S\<0\> 0) vsource dc=S0 type=dc
V2 (VCM 0) vsource dc=VCM_DC mag=VCM_AC xfmag=1 type=dc
V1 (VDDA 0) vsource dc=VDD type=dc
V7 (VINP VCM) vsource dc=VIN_DC/2 mag=VIN_AC/2 type=sine xfmag=1 ampl=VIN_AMP/2 freq=VIN_FREQ
V8 (VCM VINN) vsource dc=VIN_DC/2 mag=VIN_AC/2 type=sine xfmag=1 ampl=VIN_AMP/2 freq=VIN_FREQ
V0 (CLK 0) vsource type=pulse val0=0 val1=3.3 period=1/FC rise=1n fall=1n width=1/(2*FC)
I5 (0 net5) isource dc=200n type=dc
I3 (0 net1) isource dc=200n type=dc
C0 (VOUT 0) capacitor c=500p
I4 (net5 0 S\<2\> S\<1\> S\<0\> VDDA VOUT1 VOUT2) ecg_vga4
R0 (VOUT2 VOUT) resistor r=1200k
I2 (net1 0 VDDA VINN VINP VOUT1 CLK) ecg_ia8
simulatorOptions options reltol=100e-6 temp=27 homotopy=all limit=delta compatible=spice2 enable_pre_ver=yes ignorezerovar=yes
dcOp dc
ac ac start=0.01 stop=100M dec=30
xf ( VOUT ) xf start=0.01 stop=100M dec=30 annotate=status
