// Design: VGA/VGA_tb
simulator lang=spectre
global 0
include "/opt/pdk/ams/410/spectre/c35/soac/soac.scs"
include "/opt/pdk/ams/410/spectre/c35/soac/processOption.scs"
include "/opt/pdk/ams/410/spectre/c35/soac/cmos53.scs" section=cmostm
include "/opt/pdk/ams/410/spectre/c35/soac/res.scs" section=restm
include "/opt/pdk/ams/410/spectre/c35/soac/cap.scs" section=captm
include "/opt/pdk/ams/410/spectre/c35/soac/bip.scs" section=biptm
include "/opt/pdk/ams/410/spectre/c35/soac/ind.scs" section=indtm
include "/opt/pdk/ams/410/spectre/c35/soac/esddiode.scs" section=esddiodetm

// VGA/VGA_tb/schematic
V9 (vinn 0) vsource dc=900m type=dc
V8 (bias 0) vsource dc=1.65 type=dc
V5 (en 0) vsource dc=3.3 type=dc
V2 (vctrl 0) vsource dc=3.0 type=dc
V0 (vdda 0) vsource dc=3.3 type=dc
R0 (vout 0) resistor r=10K
V7 (vinp 0) vsource dc=900m mag=1 type=sine sinedc=900m ampl=10u freq=10K
simulatorOptions options reltol=100e-6 temp=27 homotopy=all limit=delta compatible=spice2 enable_pre_ver=yes ignorezerovar=yes
dcOp dc
