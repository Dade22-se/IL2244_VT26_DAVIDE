// Design: VGA/VGA_1_tb
simulator lang=spectre
global 0
include "/opt/pdk/ams/410/spectre/c35/soac/soac.scs"
parameters temperature=27 bias=150n S0=3.3 S1=3.3 S2=3.3 S3=3.3 V_AMP=80m VDD=3.3 VIN_PULSE=0
include "/opt/pdk/ams/410/spectre/c35/soac/processOption.scs"
include "/opt/pdk/ams/410/spectre/c35/soac/cmos53.scs" section=cmostm
include "/opt/pdk/ams/410/spectre/c35/soac/res.scs" section=restm
include "/opt/pdk/ams/410/spectre/c35/soac/cap.scs" section=captm
include "/opt/pdk/ams/410/spectre/c35/soac/bip.scs" section=biptm
include "/opt/pdk/ams/410/spectre/c35/soac/ind.scs" section=indtm
include "/opt/pdk/ams/410/spectre/c35/soac/esddiode.scs" section=esddiodetm

// VGA/MUX/schematic
subckt MUX A0 AI C GNDA S VDDA
    MN2 (AI S C GNDA) modn w=4u l=0.35u ng=1
    MN1 (A0 SN C GNDA) modn w=4u l=0.35u ng=1
    MN0 (SN S GNDA GNDA) modn w=0.8u l=0.35u ng=1
    MP0 (SN S VDDA VDDA) modp w=1.4u l=0.35u ng=1
ends MUX

// PRIMLIB/cpolyc/schematic
subckt cpolyc MINUS PLUS SUB
parameters pcap=15.5f area=100p perimeter=40u mmw=0
    C1 (MINUS SUB) capacitor c=pcap m=1
    C0 (PLUS MINUS) cpoly area=area perimeter=perimeter m=1 mmw=mmw
ends cpolyc

// VGA/VGA_1/schematic
subckt VGA_1 EN GNDA IBIAS S\<3\> S\<2\> S\<1\> S\<0\> VDDA VIN VOUT
    MN6 (net6 net6 GNDA GNDA) modn w=40u l=8u ng=1
    MN5 (net1 net6 GNDA GNDA) modn w=40u l=8u ng=1
    MN4 (net4 net3 GNDA GNDA) modn w=40u l=12u ng=1
    MN3 (net3 net3 GNDA GNDA) modn w=20u l=12u ng=1
    MN2 (net14 IBIAS net4 GNDA) modn w=40u l=8u ng=1
    MN1 (IBIAS IBIAS net3 GNDA) modn w=20u l=8u ng=1
    MN0 (VOUT net1 GNDA GNDA) modn w=20u l=1u ng=1
    MP6 (GNDA net7 net2 net2) modp w=6.25u l=0.35u ng=8
    MP5 (net2 net14 VDDA VDDA) modp w=10u l=12u ng=1
    MP4 (net14 net14 VDDA VDDA) modp w=20u l=12u ng=1
    MP3 (VOUT net14 VDDA VDDA) modp w=50u l=12u ng=1
    MP2 (net5 net14 VDDA VDDA) modp w=50u l=12u ng=1
    MP1 (net1 VIN net5 net5) modp w=150u l=3u ng=1
    MP0 (net6 net7 net5 net5) modp w=150u l=3u ng=1
    I3 (net2 GNDA net11 GNDA S\<3\> VDDA) MUX
    I2 (net2 GNDA net10 GNDA S\<2\> VDDA) MUX
    I1 (net2 GNDA net9 GNDA S\<1\> VDDA) MUX
    I0 (net2 GNDA net8 GNDA S\<0\> VDDA) MUX
    C11 (VOUT net13 GNDA) cpolyc m=1 pcap=171.29f area=1.23n perimeter=140u mmw=0
    C10 (VOUT net7 GNDA) cpolyc m=1 pcap=171.29f area=1.23n perimeter=140u mmw=0
    C9\<0\> (net11 net7 GNDA) cpolyc m=1 pcap=171.29f area=1.23n perimeter=140u mmw=0
    C9\<1\> (net11 net7 GNDA) cpolyc m=1 pcap=171.29f area=1.23n perimeter=140u mmw=0
    C9\<2\> (net11 net7 GNDA) cpolyc m=1 pcap=171.29f area=1.23n perimeter=140u mmw=0
    C9\<3\> (net11 net7 GNDA) cpolyc m=1 pcap=171.29f area=1.23n perimeter=140u mmw=0
    C9\<4\> (net11 net7 GNDA) cpolyc m=1 pcap=171.29f area=1.23n perimeter=140u mmw=0
    C9\<5\> (net11 net7 GNDA) cpolyc m=1 pcap=171.29f area=1.23n perimeter=140u mmw=0
    C9\<6\> (net11 net7 GNDA) cpolyc m=1 pcap=171.29f area=1.23n perimeter=140u mmw=0
    C9\<7\> (net11 net7 GNDA) cpolyc m=1 pcap=171.29f area=1.23n perimeter=140u mmw=0
    C8\<0\> (net10 net7 GNDA) cpolyc m=1 pcap=171.29f area=1.23n perimeter=140u mmw=0
    C8\<1\> (net10 net7 GNDA) cpolyc m=1 pcap=171.29f area=1.23n perimeter=140u mmw=0
    C8\<2\> (net10 net7 GNDA) cpolyc m=1 pcap=171.29f area=1.23n perimeter=140u mmw=0
    C8\<3\> (net10 net7 GNDA) cpolyc m=1 pcap=171.29f area=1.23n perimeter=140u mmw=0
    C7\<0\> (net9 net7 GNDA) cpolyc m=1 pcap=171.29f area=1.23n perimeter=140u mmw=0
    C7\<1\> (net9 net7 GNDA) cpolyc m=1 pcap=171.29f area=1.23n perimeter=140u mmw=0
    C3 (net8 net7 GNDA) cpolyc m=1 pcap=171.29f area=1.23n perimeter=140u mmw=0
    R1 (net7 VOUT) resistor r=500G
    R0 (net1 net13) resistor r=50K
ends VGA_1

// VGA/VGA_1_tb/schematic
I0 (net6 0 net5 S\<3\> S\<2\> S\<1\> S\<0\> net2 vin net8) VGA_1
C1 (vout 0) capacitor c=100p
C0 (vout 0) capacitor c=150f
V5 (net1 net3) vsource dc=1.6 xfmag=1 type=dc
V4 (S\<3\> 0) vsource dc=S3 type=dc
V3 (S\<2\> 0) vsource dc=S2 type=dc
V2 (S\<1\> 0) vsource dc=S1 type=dc
V1 (S\<0\> 0) vsource dc=S0 type=dc
V0 (net2 0) vsource dc=VDD type=dc
I8 (0 net5) isource dc=bias type=dc
V6 (vin net1) vsource mag=1 type=sine ampl=V_AMP freq=50
V7 (net3 0) vsource type=pulse val0=0 val1=VIN_PULSE period=1 delay=1u rise=1n fall=1n width=500m
R0 (net8 vout) resistor r=1M
simulatorOptions options reltol=100e-6 temp=27 homotopy=all limit=delta compatible=spice2 enable_pre_ver=yes ignorezerovar=yes
dcOp dc
tran tran stop=40m errpreset=conservative
ac ac start=10m stop=10G dec=30
noise ( vout ) noise start=10m stop=10G dec=30 iprobe=V6 annotate=status
pz ( vout ) pz iprobe=V6 freq=1
