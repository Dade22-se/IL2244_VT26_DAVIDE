// Design: VGA/VGA_1_tb
simulator lang=spectre
global 0
include "/opt/pdk/ams/410/spectre/c35/soac/soac.scs"
parameters temperature=27 tf=1n tr=1n V_FREQ=1k S0=3.3 S1=3.3 S2=3.3 S3=3.3 V_AMP=0 VDD=3.3 VIN_PULSE=10m
include "/opt/pdk/ams/410/spectre/c35/soac/processOption.scs"
include "/opt/pdk/ams/410/spectre/c35/soac/cmos53.scs" section=cmosmc
include "/opt/pdk/ams/410/spectre/c35/soac/res.scs" section=resmc
include "/opt/pdk/ams/410/spectre/c35/soac/cap.scs" section=capmc
include "/opt/pdk/ams/410/spectre/c35/soac/bip.scs" section=bipmc
include "/opt/pdk/ams/410/spectre/c35/soac/ind.scs" section=indtm
include "/opt/pdk/ams/410/spectre/c35/soac/esddiode.scs" section=esddiodemc

// VGA/MUX/schematic
subckt MUX A0 AI C GNDA S VDDA
    MN2 (AI S C GNDA) modn w=4u l=0.35u ng=1
    MN1 (A0 SN C GNDA) modn w=4u l=0.35u ng=1
    MN0 (SN S GNDA GNDA) modn w=0.8u l=0.35u ng=1
    MP0 (SN S VDDA VDDA) modp w=1.4u l=0.35u ng=1
ends MUX

// PRIMLIB/cpolyc/schematic
subckt cpolyc MINUS PLUS SUB
parameters pcap=15.5f area=100p perimeter=40u mmw=0
    C1 (MINUS SUB) capacitor c=pcap m=1
    C0 (PLUS MINUS) cpoly area=area perimeter=perimeter m=1 mmw=mmw
ends cpolyc

// PRIMLIB/rpolyhc/schematic
subckt rpolyhc PLUS MINUS REF
parameters w=10u l=10u mult=1 mmw=0 cap=14.34f
    R1 (PLUS net9) rpolyh w=w l=(0.5 * l) m=mult mmw=mmw
    R2 (net9 MINUS) rpolyh w=w l=(0.5*l) m=mult mmw=mmw
    CS0 (PLUS REF) capacitor c=(1-0.5*(1+tanh(l/200/w)))*cap/2 m=mult
    CS1 (MINUS REF) capacitor c=(1-0.5*(1+tanh(l/200/w)))*cap/2 m=mult
    CM (net9 REF) capacitor c=(0.5*(1+tanh(l/200/w))*cap) m=mult
ends rpolyhc

// VGA/VGA_1/schematic
subckt VGA_1 EN GNDA IBIAS S\<3\> S\<2\> S\<1\> S\<0\> VDDA VIN VOUT
    MN6 (net6 net6 GNDA GNDA) modn w=30u l=15u ng=1
    MN5 (net19 net6 GNDA GNDA) modn w=15u l=15u ng=2
    MN4 (net4 net3 GNDA GNDA) modn w=20u l=12u ng=1
    MN3 (net3 net3 GNDA GNDA) modn w=20u l=12u ng=1
    MN2 (net14 IBIAS net4 GNDA) modn w=20u l=8u ng=1
    MN1 (IBIAS IBIAS net3 GNDA) modn w=20u l=8u ng=1
    MN0 (VOUT net19 GNDA GNDA) modn w=10u l=1u ng=2
    MP11 (net7 net7 VOUT VOUT) modp w=1u l=0.35u ng=1
    MP10 (net17 net17 net7 net7) modp w=1u l=0.35u ng=1
    MP9 (net16 net16 net17 net17) modp w=1u l=0.35u ng=1
    MP8 (net12 net12 net16 net16) modp w=1u l=0.35u ng=1
    MP7 (net15 net15 net12 net12) modp w=1u l=0.35u ng=1
    MP5 (net2 net14 VDDA VDDA) modp w=10u l=15u ng=1
    MP4 (net14 net14 VDDA VDDA) modp w=20u l=15u ng=1
    MP3 (VOUT net14 VDDA VDDA) modp w=50u l=15u ng=10
    MP2 (net5 net14 VDDA VDDA) modp w=10u l=15u ng=10
    MP6 (GNDA net15 net2 net2) modp w=6.25u l=0.35u ng=8
    MP1 (net19 VIN net5 net5) modp w=100u l=4u ng=1
    MP0 (net6 net15 net5 net5) modp w=100u l=4u ng=1
    I3 (net2 GNDA net11 GNDA S\<3\> VDDA) MUX
    I2 (net2 GNDA net10 GNDA S\<2\> VDDA) MUX
    I1 (net2 GNDA net9 GNDA S\<1\> VDDA) MUX
    I5 (net2 GNDA net1 GNDA S\<0\> VDDA) MUX
    C11 (VOUT net20 GNDA) cpolyc m=1 pcap=171.29f area=1.23n perimeter=140u mmw=0
    C10 (VOUT net15 GNDA) cpolyc m=1 pcap=171.29f area=1.23n perimeter=140u mmw=0
    C7\<0\> (net9 net15 GNDA) cpolyc m=1 pcap=171.29f area=1.23n perimeter=140u mmw=0
    C7\<1\> (net9 net15 GNDA) cpolyc m=1 pcap=171.29f area=1.23n perimeter=140u mmw=0
    C3 (net1 net15 GNDA) cpolyc m=1 pcap=171.29f area=1.23n perimeter=140u mmw=0
    C9\<0\> (net11 net15 GNDA) cpolyc m=1 pcap=171.29f area=1.23n perimeter=140u mmw=0
    C9\<1\> (net11 net15 GNDA) cpolyc m=1 pcap=171.29f area=1.23n perimeter=140u mmw=0
    C9\<2\> (net11 net15 GNDA) cpolyc m=1 pcap=171.29f area=1.23n perimeter=140u mmw=0
    C9\<3\> (net11 net15 GNDA) cpolyc m=1 pcap=171.29f area=1.23n perimeter=140u mmw=0
    C9\<4\> (net11 net15 GNDA) cpolyc m=1 pcap=171.29f area=1.23n perimeter=140u mmw=0
    C9\<5\> (net11 net15 GNDA) cpolyc m=1 pcap=171.29f area=1.23n perimeter=140u mmw=0
    C9\<6\> (net11 net15 GNDA) cpolyc m=1 pcap=171.29f area=1.23n perimeter=140u mmw=0
    C9\<7\> (net11 net15 GNDA) cpolyc m=1 pcap=171.29f area=1.23n perimeter=140u mmw=0
    C8\<0\> (net10 net15 GNDA) cpolyc m=1 pcap=171.29f area=1.23n perimeter=140u mmw=0
    C8\<1\> (net10 net15 GNDA) cpolyc m=1 pcap=171.29f area=1.23n perimeter=140u mmw=0
    C8\<2\> (net10 net15 GNDA) cpolyc m=1 pcap=171.29f area=1.23n perimeter=140u mmw=0
    C8\<3\> (net10 net15 GNDA) cpolyc m=1 pcap=171.29f area=1.23n perimeter=140u mmw=0
    R2 (net19 net20 GNDA) rpolyhc w=2u l=150u mult=1 mmw=0 cap=50.7f
ends VGA_1

// VGA/VGA_1_tb/schematic
I0 (net6 0 net5 S\<3\> S\<2\> S\<1\> S\<0\> net2 vin vout) VGA_1
C1 (vout_filt 0) capacitor c=1n
V5 (net1 net3) vsource dc=1.6 xfmag=1 type=dc
V4 (S\<3\> 0) vsource dc=S3 type=dc
V3 (S\<2\> 0) vsource dc=S2 type=dc
V2 (S\<1\> 0) vsource dc=S1 type=dc
V1 (S\<0\> 0) vsource dc=S0 type=dc
V0 (net2 0) vsource dc=VDD type=dc
I8 (0 net5) isource dc=200n type=dc
V6 (vin net1) vsource mag=1 type=sine ampl=V_AMP freq=V_FREQ
V7 (net3 0) vsource type=pulse val0=0 val1=VIN_PULSE period=1 delay=1u rise=tr fall=tf width=500m
R0 (vout vout_filt) resistor r=100k
simulatorOptions options reltol=100e-6 temp=27 homotopy=all limit=delta compatible=spice2 enable_pre_ver=yes ignorezerovar=yes
mc1 montecarlo numruns=13 seed=12345 variations=all sampling=lds donominal=yes scalarfile="../monteCarlo/mcdata" paramfile="../monteCarlo/mcparam" saveprocessparams=no savemismatchparams=no savefamilyplots=yes savedatainseparatedir=yes wfseparation=yes {
dcOp dc
tran tran stop=40m errpreset=conservative
ac ac start=10m stop=100M dec=30
noise ( vout_filt ) noise start=10m stop=100M dec=30 iprobe=V6 annotate=status
pz ( vout ) pz iprobe=V6 freq=1
}
