// Point Netlist Generated on: Apr 15 12:44:55 2026
// Generated for: spectre
// Design Netlist Generated on: Apr 10 12:38:50 2026
// Design library name: VGA
// Design cell name: VGA_1_pss_tb
// Design view name: schematic
simulator lang=spectre
global 0
include "/opt/pdk/ams/410/spectre/c35/soac/soac.scs"
parameters S0=3.3 S1=3.3 S2=3.3 S3=3.3 V_AMP=20m V_FREQ=50 VDD=3.3
include "/opt/pdk/ams/410/spectre/c35/processOption.scs"
include "/opt/pdk/ams/410/spectre/c35/cmos53.scs" section=cmosmc
include "/opt/pdk/ams/410/spectre/c35/res.scs" section=resmc
include "/opt/pdk/ams/410/spectre/c35/cap.scs" section=capmc
include "/opt/pdk/ams/410/spectre/c35/bip.scs" section=bipmc
include "/opt/pdk/ams/410/spectre/c35/ind.scs" section=indmc
include "/opt/pdk/ams/410/spectre/c35/esddiode.scs" section=esddiodemc
include "netlist"
