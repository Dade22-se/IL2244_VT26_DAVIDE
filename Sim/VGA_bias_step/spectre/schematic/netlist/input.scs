// Design: VGA/VGA_bias_step
simulator lang=spectre
global 0
include "/opt/pdk/ams/410/spectre/c35/soac/soac.scs"
include "/opt/pdk/ams/410/spectre/c35/soac/processOption.scs"
include "/opt/pdk/ams/410/spectre/c35/soac/cmos53.scs" section=cmostm
include "/opt/pdk/ams/410/spectre/c35/soac/res.scs" section=restm
include "/opt/pdk/ams/410/spectre/c35/soac/cap.scs" section=captm
include "/opt/pdk/ams/410/spectre/c35/soac/bip.scs" section=biptm
include "/opt/pdk/ams/410/spectre/c35/soac/ind.scs" section=indtm
include "/opt/pdk/ams/410/spectre/c35/soac/esddiode.scs" section=esddiodetm

// VGA/VGA_bias_step/schematic
MP1 (0 net6 net1 net1) modp w=10u l=0.35u ng=1
MP0 (net2 net5 net1 net1) modp w=10u l=0.35u ng=1
MN0 (out net2 net3 net3) modn w=10u l=0.35u ng=1
V1 (net5 0) vsource dc=1.6 type=dc
V0 (net4 0) vsource dc=3.3 type=dc
I8 (net3 0) isource dc=100n type=dc
I7 (0 net2) isource dc=100n type=dc
I6 (net1 net4) isource dc=200n type=dc
C2 (out 0) capacitor c=150f
C1 (net6 0) capacitor c=500.0f
C0 (net6 out) capacitor c=39.5p
simulatorOptions options reltol=100e-6 temp=27 homotopy=all limit=delta compatible=spice2 enable_pre_ver=yes ignorezerovar=yes
dcOp dc
