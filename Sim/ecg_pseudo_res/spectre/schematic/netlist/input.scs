// Design: ECG_IA/ecg_pseudo_res
simulator lang=spectre
global 0
include "/opt/pdk/ams/410/spectre/c35/soac/soac.scs"
parameters VIN=0
include "/opt/pdk/ams/410/spectre/c35/soac/processOption.scs"
include "/opt/pdk/ams/410/spectre/c35/soac/cmos53.scs" section=cmostm
include "/opt/pdk/ams/410/spectre/c35/soac/res.scs" section=restm
include "/opt/pdk/ams/410/spectre/c35/soac/cap.scs" section=captm
include "/opt/pdk/ams/410/spectre/c35/soac/bip.scs" section=biptm
include "/opt/pdk/ams/410/spectre/c35/soac/ind.scs" section=indtm
include "/opt/pdk/ams/410/spectre/c35/soac/esddiode.scs" section=esddiodetm

// ECG_IA/ecg_pseudo_res/schematic
V0 (VIN 0) vsource dc=VIN type=dc
MP1 (VIN VIN net1 net1) modp w=1u l=0.35u ng=1
MP0 (net1 net1 0 0) modp w=1u l=0.35u ng=1
simulatorOptions options reltol=100e-6 temp=27 homotopy=all limit=delta compatible=spice2 enable_pre_ver=yes ignorezerovar=yes
dc dc param=VIN start=0 stop=1 step=0.1
save V0:p
